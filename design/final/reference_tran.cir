* EE4525 transient bench: the FIXED test circuit (assignment fig. 1). Copy to design/work/.
* The amplifier (core + CMFB + bias block) lives in amp.inc and connects only through:
*   vip vin   amplifier inputs (summing nodes)     vop von   amplifier outputs
*   vdd       amplifier supply (source Vdd, its current is the graded power)
*   vddb      bias-block supply (excluded)          vcmr      0.9 V CM reference (ideal source allowed)
* Sign: input+ -> Cin -> vin, Cfb from vop to vin, so V(von,vop) is the positive output step.
* Tunables live in .param lines so tools/lt.py sweep / tools/optimize.py can override them.
.lib 'C:\Program Files\LTC\LTspiceXVII\lib\cmp\log018.l' TT
.param VDD=1.8 VCM=0.9 VCMI=0.9
.param Cin=2.15p Cfb={Cin/4} Cload={Cin} Rin=100Meg Rfb={4*Rin}
.param VoutStep=1.2 VinStep={VoutStep/4} tstep=10n Tsettle=25n tstop={tstep+Tsettle+45n} trise=50p

Vdd vdd 0 {VDD}
Vddb vddb 0 {VDD}
Vcmr vcmr 0 {VCM}
Vinp inp 0 PULSE({VCMI} {VCMI+VinStep/2} {tstep} {trise} {trise} 1 2) AC 0.5
Vinn inn 0 PULSE({VCMI} {VCMI-VinStep/2} {tstep} {trise} {trise} 1 2) AC -0.5
Cin1 inp vin {Cin}
Rin1 inp vin {Rin} noiseless
Cin2 inn vip {Cin}
Rin2 inn vip {Rin} noiseless
Cfb1 vop vin {Cfb}
Rfb1 vop vin {Rfb} noiseless
Cfb2 von vip {Cfb}
Rfb2 von vip {Rfb} noiseless
Cload1 vop 0 {Cload}
Cload2 von 0 {Cload}

* ---- begin amp.inc ----
* EE4525 attempt 3: telescopic cascode stage 1 + push-pull common-source stage 2 (PMOS gate AC-coupled).
* External nets: vip vin (inputs)  vop von (outputs)  vdd (amp supply)  vddb (bias supply)
*                vcmr (0.9 V CM reference)  0 (ground)
* Stage-1 devices (except the PMOS cascodes), the stage-2 PMOS sources and the CMFB tail and diodes are integer
* multiples (m) of units that also appear in the bias-block replica (tail, input, NMOS cascode, load), so vbp and
* vbn come from scaled copies of the devices they bias (TA: replica bias). vcn, vcp: EE4520-style diodes.
*
* ---- unit devices (W per finger, L) ----
.param Lt=0.5u  Wt=4.3u           ; PMOS tail / current-source unit (stage-1 tail, stage-2 load, CMFB tail)
.param Li=0.18u Wi=5u             ; PMOS input unit
.param Lcp=0.25u Wcp=3u           ; PMOS cascode unit
.param Lcn=0.25u Wcn=0.8u         ; NMOS cascode unit
.param Ll=2u    Wl=2.8u           ; NMOS load unit
.param Ld=0.25u Wd=8.5u           ; NMOS stage-2 driver width at M2=20 (scaled with M2: same gm/ID)
* ---- multipliers: N units per stage-1 half, stage-2 current = M2 tail units, CMFB ----
.param N=9 Ncm=1 M2=11 Mcmt=2 Md=1
* ---- bias block: one master current, fixed ratios (assignment: fixed Ibcn/Ibnp, Ibcp/Ibnp) ----
.param Ibnp=6.4u kcn=6 kcp=4 Wbcn=0.34u Lbcn={Lcn} Wbcp=0.36u Lbcp={Lcp} Rdec=1k Cbig=10n
* ---- compensation and CMFB ----
* Rz tracks the p2-cancelling value (1/gm2)(Cc+CLeff)/Cc, normalised to Rz0*2 at M2 10, Cc 0.8p, Cin 2p
.param Cc=0.77p Rz0=1.2k Rz={Rz0*(20/M2)*((Cc+1.2*Cin)/Cc)/4} Cls=0.68p Rb=2Meg Rcm=2Meg Ccm=50f Lcm=0.36u Wcm=8u

* ===== bias block (on vddb, excluded from power) =====
* P replica: tail unit + input unit (gate at the input CM), tail gate from the input unit's drain
MBP0 bp0 vbpr vddb vddb pch l={Lt} w={Wt} m=1
MBP1 vbpr vcmr bp0 bp0 pch l={Li} w={Wi} m=1
IBNP vbpr 0 {Ibnp}
* N replica: Ibnp into NMOS cascode unit + load unit, load gate from the cascode drain (stage-1 output level)
IBNN vddb vbnr {Ibnp}
MBN5 vbnr vcn bn5 0 nch l={Lcn} w={Wcn} m=1
MBN7 bn5 vbnr 0 0 nch l={Ll} w={Wl} m=1
* cascode gate voltages: wide-swing diodes of the cascode type and length (EE4520 fig. 6: Ibcn, Ibcp)
IBCN vddb vcnr {kcn*Ibnp}
MBN3 vcnr vcnr 0 0 nch l={Lbcn} w={Wbcn} m=1
MBP3 vcpr vcpr vddb vddb pch l={Lbcp} w={Wbcp} m=1
IBCP vcpr 0 {kcp*Ibnp}
* decoupling of every bias line
RD1 vbpr vbp {Rdec}
CD1 vbp 0 {Cbig}
RD2 vbnr vbn {Rdec}
CD2 vbn 0 {Cbig}
RD3 vcnr vcn {Rdec}
CD3 vcn 0 {Cbig}
RD4 vcpr vcp {Rdec}
CD4 vcp 0 {Cbig}

* ===== stage 1: PMOS-input telescopic cascode =====
M0 tail vbp vdd vdd pch l={Lt} w={Wt} m={2*N}
M1 a1p vip tail tail pch l={Li} w={Wi} m={N}
M2 a1n vin tail tail pch l={Li} w={Wi} m={N}
M3 x1p vcp a1p vdd pch l={Lcp} w={Wcp} m={N}
M4 x1n vcp a1n vdd pch l={Lcp} w={Wcp} m={N}
M5 x1p vcn b1p 0 nch l={Lcn} w={Wcn} m={N}
M6 x1n vcn b1n 0 nch l={Lcn} w={Wcn} m={N}
M7 b1p vbn 0 0 nch l={Ll} w={Wl} m={N-Ncm}
M8 b1n vbn 0 0 nch l={Ll} w={Wl} m={N-Ncm}
M7C b1p vcmfb 0 0 nch l={Ll} w={Wl} m={Ncm}
M8C b1n vcmfb 0 0 nch l={Ll} w={Wl} m={Ncm}

* ===== stage 2: NMOS common source, PMOS current-source load =====
M9 vop x1p 0 0 nch l={Ld} w={Wd*M2/20} m={Md}
M10 von x1n 0 0 nch l={Ld} w={Wd*M2/20} m={Md}
M11 vop gp1 vdd vdd pch l={Lt} w={Wt} m={M2}
M12 von gp2 vdd vdd pch l={Lt} w={Wt} m={M2}
CLS1 x1p gp1 {Cls}
RB1 gp1 vbp {Rb}
CLS2 x1n gp2 {Cls}
RB2 gp2 vbp {Rb}

* ===== Miller compensation with nulling resistor =====
CC1 x1p zp {Cc}
RZ1 zp vop {Rz}
CC2 x1n zn {Cc}
RZ2 zn von {Rz}

* ===== CMFB: resistive sense, PMOS pair against vcmr, mirror into Ncm load units per side =====
RCM1 vop vcms {Rcm}
CCM1 vop vcms {Ccm}
RCM2 von vcms {Rcm}
CCM2 von vcms {Ccm}
MC0 cmt vbp vdd vdd pch l={Lt} w={Wt} m={Mcmt}
MC1 vcmfb vcms cmt vdd pch l={Lcm} w={Wcm} m=1
MC2 cmd vcmr cmt vdd pch l={Lcm} w={Wcm} m=1
MC3 vcmfb vcmfb 0 0 nch l={Ll} w={Wl} m=1
MC4 cmd cmd 0 0 nch l={Ll} w={Wl} m=1
* ---- end amp.inc ----

.tran 0 {tstop} 0 2p
.option plotwinsize=0 method=trap reltol=1e-4
* quick-look measurements (tools/metrics.py is the authority: floors, ringing, tau, power rule)
.meas tran vg25 FIND V(vip,vin) AT={tstep+Tsettle}
.meas tran vod25 FIND V(von,vop) AT={tstep+Tsettle}
.meas tran A25 PARAM 20*log10(VoutStep/(abs(vg25)+1n))
.meas tran Ab25 PARAM 20*log10(VoutStep/(abs(VoutStep-vod25)+1n))
.meas tran errmax MAX abs(VoutStep-V(von,vop)) FROM={tstep+Tsettle} TO={tstop}
.meas tran Abfloor PARAM 20*log10(VoutStep/(errmax+1n))
.meas tran Iset AVG -I(Vdd) FROM={tstep} TO={tstep+Tsettle}
.meas tran Iq AVG -I(Vdd) FROM={tstep-5n} TO={tstep}
.meas tran P_mW PARAM 1.8*max(Iset,Iq)*1e3
.meas tran T30 WHEN 20*log10(VoutStep/(abs(VoutStep-V(von,vop))+1n))=30 RISE=1
.meas tran T38p6 WHEN 20*log10(VoutStep/(abs(VoutStep-V(von,vop))+1n))=38.6 RISE=1
.meas tran T30_step PARAM T30-tstep
.meas tran T38p6_step PARAM T38p6-tstep
.meas tran tau PARAM T38p6-T30
.end
